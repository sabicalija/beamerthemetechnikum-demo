* RC Low-Pass Filter
* Cutoff frequency: ~1.59 kHz

V1 in 0 AC 1 SIN(0 1 1k)
R1 in out 1k
C1 out 0 100n

.ac dec 100 10 100k
.tran 0 5m 0 1u

.end
